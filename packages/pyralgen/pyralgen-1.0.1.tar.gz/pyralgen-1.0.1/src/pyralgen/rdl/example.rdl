//=============================================================================
// [Filename]       ral.rdl
// [Project]        -
// [Author]         Ciro Bermudez - cirofabian.bermudez@gmail.com
// [Language]       SystemRDL 2.0 (Register Description Language)
// [Created]        Nov 2024
// [Modified]       -
// [Description]    SystemRDL file to describe and manage the registers
// [Notes]          -
// [Status]         devel
// [Revisions]      -
//=============================================================================

// ================================= DEFAULTS =================================
default regwidth = 8;
default sw = rw;
default hw = r;

// ================================= TEMPLATES =================================

// ==============================================================================
// Name:    SET_TDC_DCO1_XX
// Range:   [0x00 to 0x3F] or [0 to 63]
// Default: 8'h1F or 8'b0001_1111
// ==============================================================================
reg tdc_reg {
  name = "";
  desc = "";
  field {
    name = "";
    desc = "";
  } feon[7:7] = 1'b0;
  field {
    name = "";
    desc = "";
  } pxon[6:6] = 1'b0;
  field {
    name = "";
    desc = "";
  } adj1[5:4] = 2'b01;
  field {
    name = "";
    desc = "";
  } ctrl1[3:0] = 4'b1111;
};

// ==============================================================================
// Name:    SET_TDC_CTRL_ALL
// Range:   [0x40] or [64]
// Default: 8'h10 or 8'b0001_0000
// ==============================================================================
reg tdc_ctrl_reg {
  name = "";
  desc = "";
  field {
    name = "";
    desc = "";
  } endetot[7:7] = 1'b0;
  field {
    name = "";
    desc = "";
  } tdcon[6:6] = 1'b0;
  field {
    name = "";
    desc = "";
  } adj0[5:4] = 2'b01;
  field {
    name = "";
    desc = "";
  } ctrl0[3:0] = 4'b0000;
};

// ==============================================================================
// Name:    SET_TDC_TPsel_X
// Range:   [0x41 to 0x42] or [65 to 66]
// Default: 8'h00 or 8'b0000_0000
// ==============================================================================
reg tdc_tpsel_reg {
  name = "";
  desc = "";
  field {
    desc = "Channel Mode";
  } ch_mode[7:6] = 2'b00;
  field {
    desc = "Channel selector";
  } ch_sel[5:0] = 6'b00_0000;
};

// ==============================================================================
// Name:    SET_AFE_TDC_GLOBAL
// Range:   [0x43] or [67]
// Default: 8'h83 or 8'b1000_0011
// ==============================================================================
reg afe_tdc_global_reg {
  name = "";
  desc = "";
  field {
    desc = "";
  } con_pad[7:7] = 1'b1;
  field {
    desc = "";
  } en_p_vth[6:6] = 1'b0;
  field {
    desc = "";
  } en_p_vldo[5:5] = 1'b0;
  field {
    desc = "";
  } en_p_vfb[4:4] = 1'b0;
  field {
    desc = "";
  } entimeout[3:3] = 1'b0;
  field {
    desc = "";
  } calmode[2:2] = 1'b0;
  field {
    desc = "";
  } selcaltime[1:0] = 2'b11;
};

// ==============================================================================
// Name:    SET_AFE_GLOBAL_0
// Range:   [0x44] or [68]
// Default: 8'h00 or 8'b0000_0000
// ==============================================================================
reg afe_global0_reg {
  name = "";
  desc = "";
  field {
    desc = "";
  } afe_lb[7:7] = 1'b0;
  field {
    desc = "";
  } afe_auto[6:6] = 1'b0;
  field {
    desc = "";
  } dac_idisc[5:3] = 3'b00;
  field {
    desc = "";
  } dac_icsa[2:0] = 3'b00;
};

// ==============================================================================
// Name:    SET_AFE_GLOBAL_1
// Range:   [0x45] or [69]
// Default: 8'h00 or 8'b0000_0000
// ==============================================================================
reg afe_global1_reg {
  name = "";
  desc = "";
  field {
    desc = "";
  } ext_dc[7:7] = 1'b0;
  field {
    desc = "";
  } en_p_vinj[6:6] = 1'b0;
  field {
    desc = "";
  } sel_vinjmux[5:3] = 3'b000;
  field {
    desc = "";
  } dac_ikrum[2:0] = 3'b000;
};

// ==============================================================================
// Name:    SET_DAC_VTH_H
// Range:   [0x46] or [70]
// Default: 8'h7F or 8'b0111_1111
// ==============================================================================
reg dac_vth_h_reg {
  name = "";
  desc = "";
  field {
    desc = "";
  } en_dac[7:7] = 1'b0;
  field {
    desc = "";
  } dac_vth_h[6:0] = 7'b111_1111;
};

// ==============================================================================
// Name:    SET_DAC_VTH_L
// Range:   [0x47] or [71]
// Default: 8'h7F or 8'b0111_1111
// ==============================================================================
reg dac_vth_l_reg {
  name = "";
  desc = "";
  field {
    desc = "";
  } en_dac[7:7] = 1'b0;
  field {
    desc = "";
  } dac_vth_l[6:0] = 7'b111_1111;
};

// ==============================================================================
// Name:    SET_DAC_VINJ_H
// Range:   [0x48] or [72]
// Default: 8'h00 or 8'b0000_0000
// ==============================================================================
reg dac_vinj_h_reg {
  name = "";
  desc = "";
  field {
    desc = "";
  } en_dac[7:7] = 1'b0;
  field {
    desc = "";
  } dac_vinj_h[6:0] = 7'b000_0000;
};

// ==============================================================================
// Name:    SET_DAC_VINJ_L 
// Range:   [0x49] or [73]
// Default: 8'h00 or 8'b0000_0000
// ==============================================================================
reg dac_vinj_l_reg {
  name = "";
  desc = "";
  field {
    desc = "";
  } en_dac[7:7] = 1'b0;
  field {
    desc = "";
  } dac_vinj_l[6:0] = 7'b000_0000;
};

// ==============================================================================
// Name:    SET_DAC_VLDO
// Range:   [0x4A] or [74]
// Default: 8'h3F or 8'b0011_1111
// ==============================================================================
reg dac_vldo_reg {
  name = "";
  desc = "";
  field {
    desc = "";
  } en_dac[7:7] = 1'b0;
  field {
    desc = "";
  } dac_vldo[6:0] = 7'b011_1111;
};

// ==============================================================================
// Name:    SET_DAC_VFB
// Range:   [0x4B] or [75]
// Default: 8'h3F or 8'b0011_1111
// ==============================================================================
reg dac_vfb_reg {
  name = "";
  desc = "";
  field {
    desc = "";
  } en_dac[7:7] = 1'b0;
  field {
    desc = "";
  } dac_vfb[6:0] = 7'b011_1111;
};

// ==============================================================================
// Name:    SET_FTDAC_(XX+1)_XX
// Range:   [0x4C to 0x6B] or [76 to 107]
// Default: 8'hFF or 8'b1111_1111
// ==============================================================================
reg ftdac_reg {
  name = "";
  desc = "";
  field {
    desc = "FT DAC 1";
  } ft_dac1[7:4] = 4'b1111;
  field {
    desc = "FT DAC 0";
  } ft_dac0[3:0] = 4'b1111;
};

// ==============================================================================
// Name:    COMMAND
// Range:   [0x70] or [112]
// Default: 8'h00 or 8'b0000_0000
// ==============================================================================
reg cmd_reg {
  name = "";
  desc = "";
  field {
    desc = "DAQres";
  } daqres[7:7] = 1'b0;
  field {
    desc = "Empty";
  } empty[6:5] = 2'b00;
  field {
    desc = "CalSelDco";
  } calseldco[4:4] = 1'b0;
  field {
    desc = "dcoC_G3";
  } dcoc_g3[3:3] = 1'b0;
  field {
    desc = "dcoC_G2";
  } dcoc_g2[2:2] = 1'b0;
  field {
    desc = "dcoC_G1";
  } dcoc_g1[1:1] = 1'b0;
  field {
    desc = "dcoC_G0";
  } dcoc_g0[0:0] = 1'b0;
};

// ================================ ADDRESS MAP ================================

addrmap mattonella_reg_block {
    name = "Mattonella registers";
    desc = "This is the SystemRDL description of Mattonella";

    // Instantiate the TDC registers
    tdc_reg              SET_TDC_DCO1_00     @ 00;
    tdc_reg              SET_TDC_DCO1_01     @ 01;

    // Instantiate TDC Control All
    tdc_ctrl_reg         SET_TDC_CTRL_ALL    @ 64;

    // Instantiate TDC TP Selector
    tdc_tpsel_reg        SET_TDC_TPSEL_0     @ 65;
    tdc_tpsel_reg        SET_TDC_TPSEL_1     @ 66;

    // Instantiate Global setting configurations
    afe_tdc_global_reg   SET_AFE_TDC_GLOBAL  @ 67;
    afe_global0_reg      SET_AFE_GLOBAL_0    @ 68;
    afe_global1_reg      SET_AFE_GLOBAL_1    @ 69;

    // Instantiate DAC Voltage configurations
    dac_vth_h_reg        SET_DAC_VTH_H       @ 70;
    dac_vth_l_reg        SET_DAC_VTH_L       @ 71;
    dac_vinj_h_reg       SET_DAC_VINJ_H      @ 72;
    dac_vinj_l_reg       SET_DAC_VINJ_L      @ 73;
    dac_vldo_reg         SET_DAC_VLDO        @ 74;
    dac_vfb_reg          SET_DAC_VFB         @ 75;

    // Instantiate FTDAC registers
    ftdac_reg            SET_FTFAC_01_00     @ 76;
    ftdac_reg            SET_FTFAC_03_02     @ 77;
    
    // Instantiate command register
    cmd_reg              COMMAND             @ 112;
};
